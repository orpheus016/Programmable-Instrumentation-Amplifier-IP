** sch_path: /foss/designs/Programmable-Instrumentation-Amplifier-IP/designs/libs/tb_analog/tb_cg_ota/tb_cg_ota.sch
**.subckt tb_cg_ota
I0 VDD I_B {ib}
V2 VDD 0 {vdd}
x2 VDD VINP2 VINN2 OUT2 I_B VSS cg_ota
V6 VINP2 VSS {vicm}
C3 OUT2 VSS {cl}
X999 OUT2 VINN2 loopgainprobe
V3 VSS 0 0
**** begin user architecture code

.param temp=27
.param cl=2p
.param ib=1u
.param vdd=1.2
.param vicm=vdd/2
.param vid=0

.subckt loopgainprobe a b
Ii 0 x DC 0 AC 0
Vi x a DC 0 AC 1
Vnodebuffer b x 0
.ends loopgainprobe

.func tian_loop() {1/(1/(2*(ac1.i(v.x999.Vi)*ac2.v(x999.x)-ac1.v(x999.x)*ac2.i(v.x999.Vi))+ac1.v(x999.x)+ac2.i(v.x999.Vi))-1)}

* ===============================================================
* SIMULATION 8: MULTI-CORNER PVT STABILITY ANALYSIS (TIAN PROBE)
* Topology : Folded-Cascode OTA with Class-AB Output Stage (x2)
* PDK      : IHP SG13CMOS5L (130nm BiCMOS)
* ===============================================================

.control
* 1. Clear previous simulation memory and initialize output directory
destroy all
shell mkdir -p result

* 2. Active process corner configuration (Update both per corner run)
*    Available corners: "tt", "ss", "ff", "sf", "fs"
set corner_name = "fs"
set raw_file    = "./result/tb_cg_ota_pvt_fs.raw"
set txt_file    = "./result/tb_cg_ota_pvt.txt"

* 3. Initialize table header safely without ngspice redirection truncation
*    Uses python to create the file and header ONLY if it does not exist yet
shell python3 -c 'import os; f="./result/tb_cg_ota_pvt_all.txt"; os.path.exists(f) or open(f,"w").write("==========================================================================================n Corner | Temp(C) | VDD(V) | Vicm(V) | Av0(dB)  | Av0(V/V)  | UGBW(MHz) | PM(deg)  | GM(dB)   n==========================================================================================n")'

* Enable sequential dataset appending for the per-corner rawfile
set appendwrite

echo "=========================================================================================="
echo " STARTING PVT STABILITY SWEEP FOR CORNER: " $corner_name
echo "=========================================================================================="

* 4. Outer Loop: Operational Temperature Sweep (-40 C, 27 C, 125 C)
foreach c_temp -40 27 125

  * Update internal SPICE simulator temperature options
  set temper = $c_temp
  option temp = $c_temp

  * 5. Inner Loop: Supply Voltage Sweep (VDD +/- 10%: 1 V, 1.08 V, 1.20 V, 1.32 V. 1.45 V, 1.5 V)
  foreach v_vdd 1 1.08 1.20 1.32 1.45 1.5

    * Calculate symmetrical mid-rail common-mode reference (Vicm = VDD / 2)
    let c_vicm = $v_vdd / 2

    * Dynamically alter DC supply and common-mode input bias voltages
    alter @v2[dc] = $v_vdd
    alter @v6[dc] = $&c_vicm

    * -----------------------------------------------------------
    * TIAN CYCLE 1: VOLTAGE INJECTION (V-test)
    * -----------------------------------------------------------
    alter i.x999.ii acmag=0
    alter v.x999.vi acmag=1
    ac dec 30 1 10G
    set plot_v = $curplot

    * -----------------------------------------------------------
    * TIAN CYCLE 2: CURRENT INJECTION (I-test)
    * -----------------------------------------------------------
    alter i.x999.ii acmag=1
    alter v.x999.vi acmag=0
    ac dec 30 1 10G
    set plot_i = $curplot

    * -----------------------------------------------------------
    * DYNAMIC TIAN RECONSTRUCTION & STABILITY EXTRACTION
    * -----------------------------------------------------------
    setplot $plot_v

    * Retrieve nodal voltages and branch currents from matched AC cycles
    let v1_x = {$plot_v}.v(x999.x)
    let i1_b = {$plot_v}.v.x999.vi#branch
    let v2_x = {$plot_i}.v(x999.x)
    let i2_b = {$plot_i}.v.x999.vi#branch

    * General bilateral Tian determinant formula: D = 2*(I1*V2 - V1*I2) + V1 + I2
    let d_tian = 2 * (i1_b * v2_x - v1_x * i2_b) + v1_x + i2_b
    let t_gain = 1 / (1 - 1 / d_tian)

    * Extract real scalar vectors to avoid complex data rectification in raw files
    let loop_magnitude = real(db(t_gain))
    let loop_phase = real(180 * cph(t_gain) / pi) + 180

    * Extract key stability figures of merit
    meas ac pvt_gain find loop_magnitude at=10
    let pvt_gain_lin = 10^(pvt_gain / 20)

    meas ac pvt_ugbw when loop_magnitude=0
    meas ac pvt_pm_raw find loop_phase when loop_magnitude=0
    let pvt_pm = pvt_pm_raw - 180

    * Gain Margin evaluated at phase crossover (0 degrees)
    meas ac pvt_gm_loss find loop_magnitude when loop_phase=180
    let pvt_gm = -pvt_gm_loss

    let pvt_ugbw_mhz = pvt_ugbw / 1e6

    * Print current iteration summary to console
    echo " [" $corner_name "] T=" $c_temp "C | VDD=" $v_vdd "V | Av0=" $&pvt_gain "dB | UGBW=" $&pvt_ugbw_mhz "MHz | PM=" $&pvt_pm "deg | GM=" $&pvt_gm "dB"

    * -----------------------------------------------------------
    * SAFE TABLE DATA APPENDING
    * -----------------------------------------------------------
    * Lock numerical values to shell variables before writing
    set s_vicm     = "$&c_vicm"
    set s_gain     = "$&pvt_gain"
    set s_gain_lin = "$&pvt_gain_lin"
    set s_ugbw     = "$&pvt_ugbw_mhz"
    set s_pm       = "$&pvt_pm"
    set s_gm       = "$&pvt_gm"

    * Append row cleanly using a single consolidated string
    echo " $corner_name    | $c_temp     | $v_vdd    | $s_vicm     | $s_gain   | $s_gain_lin   | $s_ugbw     | $s_pm    | $s_gm" >> $txt_file

    * Export Bode curves to dedicated per-corner rawfile
    write $raw_file loop_magnitude loop_phase
    write ./result/tb_cg_ota_pvt_all.raw loop_magnitude loop_phase
  end
end

* 6. Restore Tian probe sources, supply voltages, and simulator options to nominal state
alter i.x999.ii acmag=0
alter v.x999.vi acmag=0
alter @v2[dc] = 1.20
alter @v6[dc] = 0.60
set temper = 27
option temp = 27

echo "=========================================================================================="
echo " Corner " $corner_name " completed and appended to " $txt_file
echo " Bode curves saved to " $raw_file
echo "=========================================================================================="
.endc

.lib /foss/designs/IHP-Open-PDK/ihp-sg13cmos5l/libs.tech/ngspice/models/cornerMOSlv.lib mos_fs
.lib /foss/designs/IHP-Open-PDK/ihp-sg13cmos5l/libs.tech/ngspice/models/cornerMOShv.lib mos_fs
.lib /foss/designs/IHP-Open-PDK/ihp-sg13cmos5l/libs.tech/ngspice/models/cornerRES.lib res_typ
.lib /foss/designs/IHP-Open-PDK/ihp-sg13cmos5l/libs.tech/ngspice/models/cornerDIO.lib dio_tt
.lib /foss/designs/IHP-Open-PDK/ihp-sg13cmos5l/libs.tech/ngspice/models/cornerCAP.lib cap_typ
.lib /foss/designs/IHP-Open-PDK/ihp-sg13cmos5l/libs.tech/ngspice/models/cornerMOSCAP.lib moscap_tt

**** end user architecture code
**.ends

* expanding   symbol:  /foss/designs/Programmable-Instrumentation-Amplifier-IP/designs/libs/core_analog/coarse_gain/cg_ota.sym #
*+ of pins=6
** sym_path: /foss/designs/Programmable-Instrumentation-Amplifier-IP/designs/libs/core_analog/coarse_gain/cg_ota.sym
** sch_path: /foss/designs/Programmable-Instrumentation-Amplifier-IP/designs/libs/core_analog/coarse_gain/cg_ota.sch
.subckt cg_ota VDD V_inp V_inn V_out I_bias VSS
*.ipin V_inn
*.ipin VDD
*.ipin VSS
*.opin V_out
*.ipin I_bias
*.ipin V_inp
XM1 F1 V_inn net6 VDD sg13_lv_pmos w=26.56u l=2u ng=4 m=1 mm_ok=1
XM2 F2 V_inp net6 VDD sg13_lv_pmos w=26.56u l=2u ng=4 m=1 mm_ok=1
XM3 net5 net5 VDD VDD sg13_lv_pmos w=7.33u l=2u ng=1 m=1 mm_ok=1
XM4 N_A net5 VDD VDD sg13_lv_pmos w=7.33u l=2u ng=1 m=1 mm_ok=1
XM7 F1 V_bn2 VSS VSS sg13_lv_nmos w=9.21u l=2u ng=1 m=1 mm_ok=1
XM8 F2 V_bn2 VSS VSS sg13_lv_nmos w=9.21u l=2u ng=1 m=1 mm_ok=1
XM_tail net6 V_btail VDD VDD sg13_lv_pmos w=7.46u l=2u ng=1 m=8 mm_ok=1
XM_ctrlp N_B V_ctrlp N_A VDD sg13_lv_pmos w=2.20u l=0.50u ng=1 m=1 mm_ok=1
XM_outp V_out N_A VDD VDD sg13_lv_pmos w=22.20u l=0.5u ng=4 m=1 mm_ok=1
XM_ctrln N_A V_ctrln N_B VSS sg13_lv_nmos w=0.84u l=0.5u ng=1 m=1 mm_ok=1
XM_outn V_out N_B VSS VSS sg13_lv_nmos w=8.4u l=0.5u ng=1 m=1 mm_ok=1
XM5 net5 V_bn1 F1 VSS sg13_lv_nmos w=6.41u l=2u ng=1 m=1 mm_ok=1
XM6 N_A V_bn1 F2 VSS sg13_lv_nmos w=6.41u l=2u ng=1 m=1 mm_ok=1
XM_mp1 net1 net1 VDD VDD sg13_lv_pmos w=2.30u l=2u ng=1 m=1 mm_ok=1
XM_mn1 net1 I_bias VSS VSS sg13_lv_nmos w=0.87u l=2u ng=1 m=1 mm_ok=1
XM_refn I_bias I_bias VSS VSS sg13_lv_nmos w=0.87u l=2u ng=1 m=1 mm_ok=1
XM_mp2 V_bn1 net1 VDD VDD sg13_lv_pmos w=11.50u l=2u ng=2 m=1 mm_ok=1
XM_mp3 V_bn2 net1 VDD VDD sg13_lv_pmos w=23u l=2u ng=4 m=1 mm_ok=1
XM_bn1 V_bn1 V_bn1 net2 VSS sg13_lv_nmos w=1.60u l=2u ng=1 m=1 mm_ok=1
XM_bn2 V_bn2 V_bn2 VSS VSS sg13_lv_nmos w=9.21u l=2u ng=1 m=1 mm_ok=1
XM_mn2 V_btail I_bias VSS VSS sg13_lv_nmos w=6u l=2u ng=1 m=1 mm_ok=1
XM_rep_tail V_btail V_btail VDD VDD sg13_lv_pmos w=7.46u l=2u ng=1 m=8 mm_ok=1
XM_mn4 N_B I_bias VSS VSS sg13_lv_nmos w=2.82u l=2u ng=1 m=1 mm_ok=1
XC1 F2 V_out cap_cmomf w=26.48e-6 l=26.48e-6 mmin=1 mmax=4 subblock=0 m=1 mm_ok=1
XC2 N_A V_out cap_cmomf w=22.07e-6 l=22.07e-6 mmin=1 mmax=4 subblock=0 m=1 mm_ok=1
XR1 net2 VSS VSS rhigh w=0.5e-6 l=17e-6 m=1 b=0 mm_ok=1
XM_mp4 V_ctrln net1 VDD VDD sg13_lv_pmos w=3.73u l=2u ng=1 m=1 mm_ok=1
XM_rep_ctrln V_ctrln V_ctrln net3 VSS sg13_lv_nmos w=0.84u l=0.5u ng=1 m=1 mm_ok=1
XM_rep_outn net3 net3 VSS VSS sg13_lv_nmos w=2.10u l=0.5u ng=1 m=1 mm_ok=1
XM_mn3 V_ctrlp I_bias VSS VSS sg13_lv_nmos w=1.41u l=2u ng=1 m=1 mm_ok=1
XM_rep_outp net4 net4 VDD VDD sg13_lv_pmos w=5.55u l=0.5u ng=1 m=1 mm_ok=1
XM_rep_ctrlp V_ctrlp V_ctrlp net4 VDD sg13_lv_pmos w=2.20u l=0.50u ng=1 m=1 mm_ok=1
XM_mp5 N_A net1 VDD VDD sg13_lv_pmos w=7.46u l=2u ng=1 m=1 mm_ok=1
.ends

.GLOBAL VDD
.end
