** sch_path: /foss/designs/Programmable-Instrumentation-Amplifier-IP/designs/libs/tb_analog/tb_cg_ota/tb_cg_ota.sch
**.subckt tb_cg_ota
x1 VDD VINN1 VINP1 OUT1 I_B VSS cg_ota
V1 VINN1 VINP1 {vid}
I0 VDD I_B {ib}
V2 VDD VSS {vdd}
V3 VSS 0 0
V4 VINN1 VSS {vicm}
C1 OUT1 VSS {cl}
x2 VDD VINN2 VINP2 OUT2 I_B VSS cg_ota
**** begin user architecture code

.param temp=27
.param cl=2p
.param ib=1u
.param vdd=1.2

.param vid=0
.param vicm=0.6
.op
.control
save all
op
shell mkdir -p result
run
write ./result/tb_cg_ota_op.raw
show all : region
let i_q = -i(v2)
let p_q = i_q * 1.2
let p_q_uw = p_q * 1e6
let i_q_ua = i_q * 1e6
echo "======================================================="
echo " Quiescent Current (I_q): " $&i_q_ua " uA"
echo " Quiescent Power (P_q): " $&p_q_uw " uW"
echo "======================================================="
.endc

.lib cornerMOSlv.lib mos_tt
.lib cornerMOShv.lib mos_tt
.lib cornerRES.lib res_typ
.lib cornerDIO.lib dio_tt

.include tb_cg_ota.save

**** end user architecture code
**.ends

* expanding   symbol:  /foss/designs/Programmable-Instrumentation-Amplifier-IP/designs/libs/core_analog/coarse_gain/cg_ota.sym #
*+ of pins=6
** sym_path: /foss/designs/Programmable-Instrumentation-Amplifier-IP/designs/libs/core_analog/coarse_gain/cg_ota.sym
** sch_path: /foss/designs/Programmable-Instrumentation-Amplifier-IP/designs/libs/core_analog/coarse_gain/cg_ota.sch
.subckt cg_ota VDD V_inp V_inn V_out I_bias VSS
*.ipin V_inp
*.ipin VDD
*.ipin VSS
*.opin V_out
*.ipin I_bias
*.ipin V_inn
XM1 F1 V_inp net3 VDD sg13_lv_pmos w=26.56u l=2u ng=4 m=1 mm_ok=1
XM2 F2 V_inn net3 VDD sg13_lv_pmos w=26.56u l=2u ng=4 m=1 mm_ok=1
XM3 net1 net1 VDD VDD sg13_lv_pmos w=7.33u l=2u ng=1 m=1 mm_ok=1
XM4 N_A net1 VDD VDD sg13_lv_pmos w=7.33u l=2u ng=1 m=1 mm_ok=1
XM7 F1 V_bn2 VSS VSS sg13_lv_nmos w=9.21u l=2u ng=1 m=1 mm_ok=1
XM8 F2 V_bn2 VSS VSS sg13_lv_nmos w=9.21u l=2u ng=1 m=1 mm_ok=1
XM_tail net3 net6 VDD VDD sg13_lv_pmos w=5.33u l=2u ng=1 m=4 mm_ok=1
XM_ctrlp N_B VSS N_A VDD sg13_lv_pmos w=2.20u l=0.50u ng=1 m=1 mm_ok=1
XM_outp V_out N_A VDD VDD sg13_lv_pmos w=22.20u l=0.5u ng=4 m=1 mm_ok=1
XM_ctrln N_A VDD N_B VSS sg13_lv_nmos w=0.84u l=0.5u ng=1 m=1 mm_ok=1
XM_outn V_out N_B VSS VSS sg13_lv_nmos w=8.40u l=0.5u ng=1 m=1 mm_ok=1
XC1 F2 V_out cap_cmomf w=22.58e-6 l=22.58e-6 mmin=1 mmax=4 subblock=0 m=1 mm_ok=1
XC2 N_A V_out cap_cmomf w=15.85e-6 l=15.85e-6 mmin=1 mmax=4 subblock=0 m=1 mm_ok=1
XM5 net1 V_bn1 F1 VDD sg13_lv_nmos w=6.41u l=2u ng=1 m=1 mm_ok=1
XM6 N_A V_bn1 F2 VDD sg13_lv_nmos w=6.41u l=2u ng=1 m=1 mm_ok=1
XM_mp1 net2 net2 VDD VDD sg13_lv_pmos w=2.30u l=2u ng=1 m=1 mm_ok=1
XM_mn1 net2 I_bias VSS VSS sg13_lv_nmos w=0.87u l=2u ng=1 m=1 mm_ok=1
XM_refn I_bias I_bias VSS VSS sg13_lv_nmos w=0.87u l=2u ng=1 m=1 mm_ok=1
XM_mp2 V_bn1 net2 VDD VDD sg13_lv_pmos w=11.50u l=2u ng=2 m=1 mm_ok=1
XM_mp3 V_bn2 net2 VDD VDD sg13_lv_pmos w=22.30u l=2u ng=4 m=1 mm_ok=1
XM_bn1 V_bn1 V_bn1 net4 VSS sg13_lv_nmos w=6.41u l=2u ng=1 m=1 mm_ok=1
XM_bn2 V_bn2 V_bn2 VSS VSS sg13_lv_nmos w=9.21u l=2u ng=1 m=1 mm_ok=1
XM_bn3 net4 V_bn2 VSS VSS sg13_lv_nmos w=4.61u l=2u ng=1 m=1 mm_ok=1
XM_mn2 net5 I_bias VSS VSS sg13_lv_nmos w=8.7u l=2u ng=1 m=1 mm_ok=1
XM_bp1 net5 net5 VDD VDD sg13_lv_pmos w=5.33u l=2u ng=1 m=4 mm_ok=1
XM_mn3 N_B I_bias VSS VSS sg13_lv_nmos w=2.82u l=2u ng=1 m=1 mm_ok=1
.ends

.GLOBAL VDD
.end
