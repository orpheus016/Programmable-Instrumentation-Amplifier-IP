** sch_path: /foss/designs/Programmable-Instrumentation-Amplifier-IP/designs/libs/tb_analog/tb_ota_cmos5l_op/tb_ota_cmos5l_op.sch
**.subckt tb_ota_cmos5l_op
x1 vss ibias VDD vinn vinp out ota_cmos5l
C1 out 0 3p
I0 ibias vss 1.4u
V1 VDD vss 1.5
V2 vss 0 0
V3 vinp vss 0.75
V4 vinn vss 0.75
**** begin user architecture code

.param temp=27
.param lbias=0.15u wbias=0.15u
.param m6=1 m7=4 m8=8
.param linpair=5u winpair=50u
.param lload=1u wload=2u
.param lcs=5u wcs=19.13u
.param Cc=2.2p
.op

.control
save all

** Simulations
op

** Measurements
show all
let Iq= -1*i(V1)
let Pota = V(vdd)*Iq
print Iq
print Pota

write tb_ota_cmos5l_op.raw

.endc
* ngspice commands

.lib cornerMOSlv.lib mos_tt
.lib cornerMOShv.lib mos_tt
.lib cornerRES.lib res_typ
.lib cornerDIO.lib dio_tt

**** end user architecture code
**.ends

* expanding   symbol:  /foss/designs/Programmable-Instrumentation-Amplifier-IP/designs/libs/core_analog/ota_cmos5l/ota_cmos5l.sym
*+ # of pins=6
** sym_path: /foss/designs/Programmable-Instrumentation-Amplifier-IP/designs/libs/core_analog/ota_cmos5l/ota_cmos5l.sym
** sch_path: /foss/designs/Programmable-Instrumentation-Amplifier-IP/designs/libs/core_analog/ota_cmos5l/ota_cmos5l.sch
.subckt ota_cmos5l VSS IBIAS VDD VINN VINP VOUT
*.iopin IBIAS
*.iopin VDD
*.iopin VSS
*.iopin VOUT
*.iopin VINP
*.iopin VINN
XM6 net1 net1 vdd vdd sg13_lv_pmos w={wbias} l={lbias} ng=1 m={m6} mm_ok=1
XM7 net5 net1 vdd vdd sg13_lv_pmos w={wbias} l={lbias} ng=1 m={m7} mm_ok=1
XM8 net6 net1 vdd vdd sg13_lv_pmos w={wbias} l={lbias} ng=1 m={m8} mm_ok=1
XM1 net7 VINN net2 vdd sg13_lv_pmos w={winpair} l={linpair} ng=1 m=1 mm_ok=1
XM2 net8 VINP net2 vdd sg13_lv_pmos w={winpair} l={linpair} ng=1 m=1 mm_ok=1
XM3 net3 net3 VSS VSS sg13_lv_nmos w={wload} l={lload} ng=1 m=1 mm_ok=1
XM4 net4 net3 VSS VSS sg13_lv_nmos w={wload} l={lload} ng=1 m=1 mm_ok=1
XM5 net9 net4 VSS VSS sg13_lv_nmos w={wcs} l={lcs} ng=1 m=1 mm_ok=1
C1 net10 net9 {Cc}
XR1 net4 net10 sub! rhigh w=0.5e-6 l=1.95e-6 m=1 b=0 mm_ok=1
VIBIAS net1 IBIAS 0
.save i(vibias)
VID7 net5 net2 0
.save i(vid7)
VID8 net6 VOUT 0
.save i(vid8)
.save v(vinp)
.save v(vinn)
.save v(vout)
VID1 net7 net3 0
.save i(vid1)
VID2 net8 net4 0
.save i(vid2)
VID5 VOUT net9 0
.save i(vid5)
.ends

.GLOBAL VDD
.end
