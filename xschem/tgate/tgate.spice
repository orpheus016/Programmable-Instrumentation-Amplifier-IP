** sch_path: /foss/designs/Chipalooza/Programmable-Instrumentation-Amplifier-IP/designs/libs/core_digital/tgate/tgate.sch
**.subckt tgate IN AVSS AVDD EN ENB OUT
*.iopin AVDD
*.iopin AVSS
*.iopin IN
*.iopin OUT
*.ipin EN
*.ipin ENB
XM1 IN EN OUT AVSS sg13_lv_nmos w=1u l=0.13u ng=1 m=1 mm_ok=1
XM2 OUT ENB IN AVDD sg13_lv_pmos w=2.5u l=0.13u ng=1 m=1 mm_ok=1
**.ends
.end
