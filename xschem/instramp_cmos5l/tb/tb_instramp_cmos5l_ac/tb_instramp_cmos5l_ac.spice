** sch_path: /foss/designs/Programmable-Instrumentation-Amplifier-IP/designs/libs/tb_analog/tb_instramp_cmos5l_ac/tb_instramp_cmos5l_ac.sch
**.subckt tb_instramp_cmos5l_ac
C1 out 0 3p
I0 ibias vss 4.2u
V1 VDD vss 1.5
V2 vss 0 0
V3 vinp vss 0.75
V4 vinn vss 0.75
x1 vss VDD ibias vinn out vinp vcm instramp_cmos5l
V5 vcm vss 0.75
**** begin user architecture code

.param temp=27
.param lbias=0.15u wbias=0.15u
.param m6=1 m7=4 m8=8
.param linpair=3u winpair=20u
.param lload=5u wload=10u
.param lcs=3u wcs=20u
.param Cc=2p
.ac DEC

.control
save all

** Set sources
alter @V3[AC] = 1

** Simulations
ac dec 100 1 10G

** Plots
setplot ac1
let gain_db = db(v(out))
plot gain_db
let phase_deg = cph(v(out))*180/pi
plot phase_deg

** Measurements
meas ac DC_gain FIND gain_db AT=1Hz
let gain_3db = DC_gain-3
meas ac f_3db WHEN gain_db=$&gain_3db
meas ac f_0db WHEN gain_db=0
meas ac phase_0db FIND phase_deg WHEN gain_db=0
let phase_margin = 180 + phase_0db
print phase_margin

write tb_instramp_cmos5l_ac.raw

.endc
* ngspice commands

.lib cornerMOSlv.lib mos_tt
.lib cornerMOShv.lib mos_tt
.lib cornerRES.lib res_typ
.lib cornerDIO.lib dio_tt

**** end user architecture code
**.ends

* expanding   symbol:
*+  /foss/designs/Programmable-Instrumentation-Amplifier-IP/designs/libs/core_analog/instramp_cmos5l/instramp_cmos5l.sym # of pins=7
** sym_path: /foss/designs/Programmable-Instrumentation-Amplifier-IP/designs/libs/core_analog/instramp_cmos5l/instramp_cmos5l.sym
** sch_path: /foss/designs/Programmable-Instrumentation-Amplifier-IP/designs/libs/core_analog/instramp_cmos5l/instramp_cmos5l.sch
.subckt instramp_cmos5l VSS VDD IBIAS VINN VOUT VINP CM
*.iopin VDD
*.iopin IBIAS
*.iopin VSS
*.iopin CM
*.iopin VOUT
*.iopin VINN
*.iopin VINP
x1 vss ibias vdd net3 VINP net4 ota_cmos5l
x2 vss ibias vdd net1 VINN net2 ota_cmos5l
x3 vss ibias vdd net5 net6 net8 ota_cmos5l
XR1 net4 net6 sub! rhigh w=0.5e-6 l=2e-6 m=1 b=0 mm_ok=1
XR2 net2 net5 sub! rhigh w=0.5e-6 l=2e-6 m=1 b=0 mm_ok=1
XR3 net6 CM sub! rhigh w=0.5e-6 l=8*2.1e-6 m=1 b=0 mm_ok=1
XR4 net5 net7 sub! rhigh w=0.5e-6 l=8*2.1e-6 m=1 b=0 mm_ok=1
Vmeas net7 net8 0
.save i(vmeas)
Vmeas1 net8 VOUT 0
.save i(vmeas1)
R5 VINN vcm 10MEG
R6 vcm VINP 10MEG
XR7 net2 net1 sub! rhigh w=0.5e-6 l=2e-6 m=1 b=0 mm_ok=1
XR8 net4 net3 sub! rhigh w=0.5e-6 l=2e-6 m=1 b=0 mm_ok=1
.ends

* expanding   symbol:  /foss/designs/Programmable-Instrumentation-Amplifier-IP/designs/libs/core_analog/ota_cmos5l/ota_cmos5l.sym
*+ # of pins=6
** sym_path: /foss/designs/Programmable-Instrumentation-Amplifier-IP/designs/libs/core_analog/ota_cmos5l/ota_cmos5l.sym
** sch_path: /foss/designs/Programmable-Instrumentation-Amplifier-IP/designs/libs/core_analog/ota_cmos5l/ota_cmos5l.sch
.subckt ota_cmos5l VSS IBIAS VDD VINN VINP VOUT
*.iopin IBIAS
*.iopin VDD
*.iopin VSS
*.iopin VOUT
*.iopin VINP
*.iopin VINN
XM6 net1 net1 vdd vdd sg13_lv_pmos w={wbias} l={lbias} ng=1 m={m6} mm_ok=1
XM7 net5 net1 vdd vdd sg13_lv_pmos w={wbias} l={lbias} ng=1 m={m7} mm_ok=1
XM8 net6 net1 vdd vdd sg13_lv_pmos w={wbias} l={lbias} ng=1 m={m8} mm_ok=1
XM1 net7 VINN net2 vdd sg13_lv_pmos w={winpair} l={linpair} ng=1 m=1 mm_ok=1
XM2 net8 VINP net2 vdd sg13_lv_pmos w={winpair} l={linpair} ng=1 m=1 mm_ok=1
XM3 net3 net3 VSS VSS sg13_lv_nmos w={wload} l={lload} ng=1 m=1 mm_ok=1
XM4 net4 net3 VSS VSS sg13_lv_nmos w={wload} l={lload} ng=1 m=1 mm_ok=1
XM5 net9 net4 VSS VSS sg13_lv_nmos w={wcs} l={lcs} ng=1 m=1 mm_ok=1
C1 net10 net9 {Cc}
XR1 net4 net10 sub! rhigh w=0.5e-6 l=1.95e-6 m=1 b=0 mm_ok=1
VIBIAS net1 IBIAS 0
.save i(vibias)
VID7 net5 net2 0
.save i(vid7)
VID8 net6 VOUT 0
.save i(vid8)
.save v(vinp)
.save v(vinn)
.save v(vout)
VID1 net7 net3 0
.save i(vid1)
VID2 net8 net4 0
.save i(vid2)
VID5 VOUT net9 0
.save i(vid5)
.ends

.GLOBAL VDD
.end
